.include /foss/designs/sar_adc/prim_cells_ngspice.mod
.include /foss/designs/sar_adc/sar_logic_ngspice.mod

* SPICE netlist generated by Yosys 0.46 (git sha1 e97731b9d, g++ 11.4.0-1ubuntu1~22.04 -fPIC -O3)

.SUBCKT sar_logic_analog comp_in clk dig_out.0 dig_out.1 dig_out.2 dig_out.3 dig_out.4 dig_out.5 dig_out.6 dig_out.7 sample dac_in.0 dac_in.1 dac_in.2 dac_in.3 dac_in.4 dac_in.5 dac_in.6 dac_in.7

* Set the ADC and DAC bridge, to set the Analog voltage equivalent of digital highs and lows
.model adc_buff adc_bridge(in_low = 0.7 in_high=1)
.model dac_buff dac_bridge(out_high = 1.8)

* assign analog inputs [A B C] to digital inputs [ad bd cd]
Aad [comp_in clk] [comp_ind clkd] adc_buff
* assign digital output [dd] to analog output [D]
Ada [dig_outd.0 dig_outd.1 dig_outd.2 dig_outd.3 dig_outd.4 dig_outd.5 dig_outd.6 dig_outd.7 sampled dac_ind.0 dac_ind.1 dac_ind.2 dac_ind.3 dac_ind.4 dac_ind.5 dac_ind.6 dac_ind.7] [dig_out.0 dig_out.1 dig_out.2 dig_out.3 dig_out.4 dig_out.5 dig_out.6 dig_out.7 sample dac_in.0 dac_in.1 dac_in.2 dac_in.3 dac_in.4 dac_in.5 dac_in.6 dac_in.7] dac_buff

Xsar_logic comp_ind clkd dig_outd.0 dig_outd.1 dig_outd.2 dig_outd.3 dig_outd.4 dig_outd.5 dig_outd.6 dig_outd.7 sampled dac_ind.0 dac_ind.1 dac_ind.2 dac_ind.3 dac_ind.4 dac_ind.5 dac_ind.6 dac_ind.7 sar_logic

.ENDS sar_logic_analog

************************
* end of SPICE netlist *
************************
